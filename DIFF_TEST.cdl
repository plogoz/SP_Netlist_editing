* Synthetic differential standard-cell stub for testing the N-lane buffer flow.
* Every signal is a (true, complement) pair, so cells are 2-in/2-out per phase.
* Not a real PDK; pin directions only. See docs/netlist_editing_workflow.md.

.SUBCKT AND2D A0 A0N A1 A1N Z ZN
*.PININFO A0:I A0N:I A1:I A1N:I Z:O ZN:O
.ENDS

.SUBCKT BUFD A AN Z ZN
*.PININFO A:I AN:I Z:O ZN:O
.ENDS

.SUBCKT DFFD CK D DN Q QN
*.PININFO CK:I D:I DN:I Q:O QN:O
.ENDS
